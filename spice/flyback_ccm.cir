* Flyback 18-32 V -> 15 V / 1 A, 200 kHz, at 18 V (Example 3, docs/example_flyback_28v.md)
* Generated by hdk.power.flyback.spice_netlist; transformer 11:11, L_m = 29.5 uH, leakage 1.5 %,
* RCD clamp sized for 2 x V_OR. Expected: primary peak about 2.54 A, clamp about 27 V above the input,
* output about 14.7 V (open loop), drain peak about 47 V.
* Run: ngspice -b flyback_ccm.cir
Vin in 0 18
Vsense in pin 0
Lp pin p1 2.94787e-05
Ls 0 sa 2.94787e-05
K1 Lp Ls 0.9999
Llk p1 sw 4.4218e-07
S1 sw 0 g 0 swm
.model swm SW(VT=0.5 VH=0.1 RON=0.02 ROFF=1e7)
Vg g 0 PULSE(0 1 0 5n 5n 2.30843e-06 5e-06)
Coss sw 0 150p
Rsn sw snb 33
Csn snb 0 220p
Dcl sw cl dcl
Rcl cl in 1361.42
Ccl cl in 3.67264e-08
Vssense sa sd 0
Do sd out dout
Cout out 0 2.2e-05
Rload out 0 15
.model dout D(IS=5u N=1.1 RS=20m)
.model dcl D(IS=1n N=1.6 RS=50m)
.ic v(out)=15 v(cl)=49
.options method=gear
.tran 5e-09 0.002 0.00195 uic
.control
run
meas tran i_p_peak MAX i(vsense)
meas tran v_out AVG v(out)
meas tran v_cl AVG v(cl)
let v_clamp = v_cl - 18
print v_clamp
meas tran v_drain_peak MAX v(sw)
.endc
.end
